# Ansys Electronics Desktop project, version 2019.1
project variables:
  $c = 299792458m_per_sec
  $f = 2.25GHz
materials:
  vacuum: permittivity=1
  FR4_epoxy: permittivity=4.4 dielectric_loss_tangent=0.02
  ferrite: permittivity=12 permeability=1000 conductivity=0.01
  polyethylene: permittivity=2.25 dielectric_loss_tangent=0.001
  copper: permeability=0.999991 conductivity=58000000
  pec: conductivity=1e+30

design Design A (HFSS, DrivenModal, model units mm)
variables:
  h = 1.56mm  # Thickness of substrate
  subX = 83mm  # Width of substrate
  subY = 114.3mm  # Length of substrate
  c = 299792458m_per_sec  # Speed of light
  fr = 2.25GHz  # Resonant frequency
  a = c/2/fr*sqrt(2/(Er+1)) m  # Width of patch
  b = (c/2/fr/sqrt(Ee)-2*dL) m  # Length of patch
  Ee = (Er+1)/2+(Er-1)/2*sqrt(1+12h/(1000a)) F_per_m  # Effective dielectric constant
  Er = 4.4F_per_m  # Dielectric constant of substrate material
  dL = 0.412h/1000*(Ee+0.3)/(Ee-0.258)*(a/h+0.264)/(a/h+0.8) meter  # Fringing field length
  Gx = 83mm  # Ground plane width for sweeping
  Gy = 114.3mm  # Ground plane length for sweeping
  Zc = 50ohm  # Coax cable impedance
  Ec = 2.25F_per_m  # Coax cable dielectric constant
  Di = 0.00091meter  # Coax cable inner conductor diameter
  Dd = Di*10^(Zc*sqrt(Ec)/138)  # Coax cable dielectric diameter
  FeedX = b/a*FeedY
  FeedY = 17m
geometry:
  Substrate [FR4_epoxy] = box(corner=(-subX/2, -subY/2, 0mm), size=(subX, subY, h))
  Patch = rectangle(corner=(-b*1000/2, -a*1000/2, h), x_size=c/2/fr/sqrt(Ee)-2*dL, y_size=c/2/fr*sqrt(2/(Er+1)))
  Ground = rectangle(corner=(-Gx/2, -Gy/2, 0mm), x_size=Gx, y_size=Gy)
  CoaxDielectric [vacuum] = cylinder(axis=Z, base_centre=(FeedX, FeedY, 0mm), radius=Dd/2, height=-20mm)
  CoaxInnerConductor [copper] = cylinder(axis=Z, base_centre=(FeedX, FeedY, h), radius=Di/2, height=-21.56mm)
  Ellipse1 = ellipse(normal=Z, centre=(FeedX, FeedY, -20mm), major_radius=Dd/2, ratio=1)
  Radiation [vacuum] = box(corner=(-(SubX+c/4/fr)/2, -(SubY+c/4/fr)/2, 0), size=(SubX+c/4/fr, SubY+c/4/fr, 20mm+h+c/2/fr))
  CoaxInnerConductor_2 = CoaxInnerConductor.copy()
  Substrate.subtract(CoaxInnerConductor_2)
  CoaxInnerConductor_3 = CoaxInnerConductor.copy()
  Ground.subtract(CoaxInnerConductor_3)
  CoaxInnerConductor_4 = CoaxInnerConductor.copy()
  CoaxDielectric.subtract(CoaxInnerConductor_4)
  CoaxDielectric_1 = CoaxDielectric.copy()
  CoaxInnerConductor_5 = CoaxInnerConductor.copy()
  Radiation.subtract(CoaxDielectric_1, CoaxInnerConductor_5)
boundaries and excitations:
  PerfE1: Perfect E Objects=Patch
  PerfE2: Perfect E Objects=Ground
  Rad1: Radiation Faces=Radiation.face(+x, +z, +y, -x, -y)
  1: Wave Port Objects=Ellipse1 NumModes=1 Modes{Mode1{IntLine{Ellipse1.face -> CoaxInnerConductor.vertex(1 of 2)} CharImp=Zpi RenormImp=50ohm}}
setups:
  Setup1: HfssDriven AdaptMultipleFreqs MultipleAdaptiveFreqsSetup{1GHz(0.02) 2.2GHz(0.02) 5GHz(0.02)} MaximumPasses=20 MinimumPasses=3 MinimumConvergedPasses=2 PercentRefinement=30 BasisOrder=1 PortAccuracy=2
    sweep FrequencySweep1: 1GHz to 2.4GHz, 300 points; Type=Interpolating InterpTolerance=0.5 InterpMaxSolns=250 InterpUsePortImped=false PassivityErrorTolerance=0.0001
source amplitudes:
  1:1: 1W 0deg
optimetrics:
  ParametricSetup1: Parametric Sim._Setups=[Setup1]
    sweep FeedY: LIN 11 20 2
radiation setups:
  Infinite Sphere1: Infinite Sphere Theta=0deg..360deg step 2deg Phi=0deg..180deg step 2deg
reports:
  S Parameter Plot 3: dB(S(1,1)) vs Freq, FeedY on Setup1 : FrequencySweep1
  S Parameter Plot 4: dB(S(1,1)) vs Freq on Setup1 : FrequencySweep1 [FeedY=all]

design Coax (HFSS, DrivenModal, model units mm)
variables:
  dL = 0.412h/1000*(Ee+0.3)/(Ee-0.258)*(a/h+0.264)/(a/h+0.8) meter  # Fringing field length
  FeedX = 5mm
  fr = 2.25GHz  # Resonant frequency
  Zc = 50ohm  # Coax cable impedance
  c = 299792458m_per_sec  # Speed of light
  Ee = (Er+1)/2+(Er-1)/2*sqrt(1+12h/(1000a)) F_per_m  # Effective dielectric constant
  b = (c/2/fr/sqrt(Ee)-2*dL) m  # Length of patch
  a = c/2/fr*sqrt(2/(Er+1)) m  # Width of patch
  Do = 4.95mm  # Coax cable outer conductor diameter
  Dd = Di*10^(Zc*sqrt(Ec)/138)  # Coax cable dielectric diameter
  Di = 0.00091meter  # Coax cable inner conductor diameter
  FeedY = (a/b*FeedX*1000) mm
  h = 1.56mm  # Thickness of substrate
  Er = 4.4F_per_m  # Dielectric constant of substrate material
  Ec = 2.25F_per_m  # Coax cable dielectric constant
geometry:
  CoaxDielectric [polyethylene] = cylinder(axis=Z, base_centre=(0, 0, 0), radius=Dd/2, height=20mm)
  CoaxInnerConductor [pec] = cylinder(axis=Z, base_centre=(0, 0, 0), radius=Di/2, height=21.56mm)
  Circle1 = circle(normal=Z, centre=(0mm, 0mm, 0mm), radius=Dd/2)
  CoaxInnerConductor_2 = CoaxInnerConductor.copy()
  CoaxDielectric.subtract(CoaxInnerConductor_2)
boundaries and excitations:
  Rad1: Radiation Faces=CoaxDielectric.face(3 of 3)
  1: Wave Port Objects=Circle1 NumModes=1 Modes{Mode1{IntLine{CoaxDielectric.edge(1 of 2) at -0.25 along -> Circle1.face} CharImp=Zpi}}
setups:
  Setup1: HfssDriven Frequency=2.2GHz MaxDeltaS=0.02 MaximumPasses=5 MinimumPasses=3 MinimumConvergedPasses=2 PercentRefinement=30 BasisOrder=1 PortAccuracy=2
    sweep Sweep: 1GHz to 10GHz, 451 points; Type=Fast SaveFields
    sweep Sweep1: 1GHz to 10GHz, 451 points; Type=Interpolating InterpTolerance=0.5 InterpMaxSolns=250 InterpUsePortImped=false PassivityErrorTolerance=0.0001
source amplitudes:
  1:1: 1W 0deg
reports:
  S Parameter Plot 1: dB(S(1,1)) vs Freq on Setup1 : Sweep
  Port Zo Plot 1: re(Zo(1)), im(Zo(1)) vs Freq on Setup1 : Sweep

design Design C (HFSS, DrivenModal, model units mm)
variables:
  Di = 0.00091meter  # Coax cable inner conductor diameter
  FeedX = 7mm
  FeedY = 0
  h = 1.56mm  # Thickness of substrate
  subX = 83mm  # Width of substrate
  subY = 114.3mm  # Length of substrate
  a = c/2/fr*sqrt(2/(Er+1)) m  # Width of patch
  b = (c/2/fr/sqrt(Ee)-2*dL) m  # Length of patch
  Ee = (Er+1)/2+(Er-1)/2*sqrt(1+12h/(1000a)) F_per_m  # Effective dielectric constant
  Er = 4.4F_per_m  # Dielectric constant of substrate material
  fr = 2.25GHz  # Resonant frequency
  dL = 0.412h/1000*(Ee+0.3)/(Ee-0.258)*(a/h+0.264)/(a/h+0.8) meter  # Fringing field length
  c = 299792458m_per_sec  # Speed of light
  Gx = 83mm  # Ground plane width for sweeping
  Gy = 114.3mm  # Ground plane length for sweeping
  Ec = 2.25F_per_m  # Coax cable dielectric constant
  Dd = Di*10^(Zc*sqrt(Ec)/138)  # Coax cable dielectric diameter
  Zc = 50ohm  # Coax cable impedance
  Notch1X = 10mm
geometry:
  Substrate [FR4_epoxy] = box(corner=(-subX/2, -subY/2, 0mm), size=(subX, subY, h))
  CoaxInnerConductor [copper] = cylinder(axis=Z, base_centre=(FeedX, FeedY, h), radius=Di/2, height=-21.56mm)
  CoaxInnerConductor_2 = CoaxInnerConductor.copy()
  Substrate.subtract(CoaxInnerConductor_2)
  Patch = rectangle(corner=(-b*1000/2, -b*1000/2, h), x_size=c/2/fr/sqrt(Ee)-2*dL, y_size=c/2/fr/sqrt(Ee)-2*dL)
  Ground = rectangle(corner=(-Gx/2, -Gy/2, 0mm), x_size=Gx, y_size=Gy)
  CoaxInnerConductor_3 = CoaxInnerConductor.copy()
  Ground.subtract(CoaxInnerConductor_3)
  CoaxDielectric [vacuum] = cylinder(axis=Z, base_centre=(FeedX, FeedY, 0mm), radius=Dd/2, height=-20mm)
  CoaxInnerConductor_4 = CoaxInnerConductor.copy()
  CoaxDielectric.subtract(CoaxInnerConductor_4)
  CoaxDielectric_1 = CoaxDielectric.copy()
  CoaxInnerConductor_5 = CoaxInnerConductor.copy()
  Ellipse1 = ellipse(normal=Z, centre=(FeedX, FeedY, -20mm), major_radius=Dd/2, ratio=1)
  Radiation [vacuum] = box(corner=(-(SubX+c/4/fr)/2, -(SubY+c/4/fr)/2, 0), size=(SubX+c/4/fr, SubY+c/4/fr, 20mm+h+c/2/fr))
  Radiation.subtract(CoaxDielectric_1, CoaxInnerConductor_5)
  Notch1 = polyline(z=1.56mm, xy: (-b*1000/2+Notch1X, b*1000/2) (-b*1000/2, b*1000/2-Notch1X) (-b*1000/2, b*1000/2) (-b*1000/2+Notch1X, b*1000/2), closed, covered)
  Notch2 = polyline(z=1.56mm, xy: (b*1000/2, -b*1000/2) (b*1000/2-Notch1X, -b*1000/2) (b*1000/2, -b*1000/2+Notch1X) (b*1000/2, -b*1000/2), closed, covered)
  Patch.subtract(Notch1, Notch2)
boundaries and excitations:
  PerfE1: Perfect E Objects=Ground
  PerfE2: Perfect E Objects=Patch
  Rad1: Radiation Faces=Radiation.face(-y, +x, +y, +z, -x)
  1: Wave Port Objects=Ellipse1 NumModes=1 Modes{Mode1{CharImp=Zpi}}
setups:
  Setup1: HfssDriven Frequency=2.25GHz MaxDeltaS=0.01 MaximumPasses=20 MinimumPasses=2 MinimumConvergedPasses=2 PercentRefinement=30 BasisOrder=1 PortAccuracy=2
    sweep Sweep: 1GHz to 10GHz, 451 points; Type=Interpolating InterpTolerance=0.5 InterpMaxSolns=250 InterpUsePortImped=false PassivityErrorTolerance=0.0001
source amplitudes:
  1:1: 1W 0deg
optimetrics:
  ParametricSetup1: Parametric disabled Sim._Setups=[Setup1]
    sweep FeedX: LIN 8mm 15mm 1mm
reports:
  S Parameter Plot 1: dB(S(1,1)) vs Freq on Setup1 : Sweep [FeedX=all]
  S Parameter Plot 2: dB(S(1,1)) vs Freq on Setup1 : Sweep [FeedX=all]
